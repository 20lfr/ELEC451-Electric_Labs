*** SPICE deck for cell inv{sch} from library elec451
*** Created on Wed Jan 07, 2026 12:33:37
*** Last revised on Wed Jan 07, 2026 13:59:01
*** Written on Wed Jan 07, 2026 14:07:02 by Electric VLSI Design System, version 9.08
*** Layout tech: mocmos, foundry MOSIS
*** UC SPICE *** , MIN_RESIST 4.0, MIN_CAPAC 0.1FF

.global gnd vdd

*** TOP LEVEL CELL: inv{sch}
Mnmos@0 b a gnd gnd NMOS L=0.6U W=0.9U
Mpmos@0 vdd a b vdd PMOS L=0.6U W=1.8U

* Spice Code nodes in cell cell 'inv{sch}'
.include C5_models.txt
Vdd vdd gnd 5
Vin a gnd PULSE 0 5 1n 0.1n 0.1n 0.4n 1n
.tran 3n
.END
